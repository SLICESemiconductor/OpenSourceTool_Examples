////////////////////////////////////////////////////////////////
// Netlist generated by : Diarmuid Collins
// Date : Mon Feb 05
////////////////////////////////////////////////////////////////

// Library Name : xxx
// Cell Name : OTA_vcvs
// View Name : veriloga
////////////////////////////////////////////////////////////////

`include "constants.vams"
`include "disciplines.vams"

module OTA_vcvs (vdda, vout, vinn, vinp, ibias_1u, vssa);

input vdda;
input ibias_1u;
input vinn;
input vinp;
input vssa;
output vout;

electrical vdda, vout, vinn, vinp, ibias_1u, vssa;

// Parameters
parameter real Aol_0 = 80; // Open loop gain in dB
parameter real GBW = 10e6; // Gain Bandwidth in Hz

analog begin

	V(vout,vssa) <+  pow(10,Aol_0/20)*V(vinp,vinn);
        $display("OTA_vcvs: vinn=%g voutp=%g --> vout=%g", V(vinn), V(vinp), V(vout));

       end

endmodule
